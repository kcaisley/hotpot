* nand.sp
.SUBCKT NAND2_X1 A1 A2 ZN VDD VSS
*.PININFO A1:I A2:I ZN:O VDD:P VSS:G
*.EQN ZN=!(A1 * A2)
M_i_1 net_0 A2 VSS VSS NMOS_VTL
+ W=0.415000U L=0.050000U
M_i_0 ZN A1 net_0 VSS NMOS_VTL
+ W=0.415000U L=0.050000U
M_i_3 ZN A2 VDD VDD PMOS_VTL
+ W=0.630000U L=0.050000U
M_i_2 VDD A1 ZN VDD PMOS_VTL
+ W=0.630000U L=0.050000U
.ENDS
