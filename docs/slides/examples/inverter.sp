* inverter.sp
.SUBCKT INV_X1 A ZN VDD VSS
*.PININFO A:I ZN:O VDD:P VSS:G
*.EQN ZN=!A
M_i_0 ZN A VSS VSS NMOS_VTL W=.415U L=.05U
M_i_1 ZN A VDD VDD PMOS_VTL W=.63U L=.05U
.ENDS
